// VBIC as ngspice 47 runs it (levels 4 and 9), generated by tests/models/vbic_gen.py from ngspice's
// vbictemp.c and vbicload.c (copyright 1990 Regents of the University of California; model author 1995
// Colin McAndrew, Motorola; Spice3 implementation 2003 Dietmar Warning, DAnalyse; ngspice's modified BSD).
`include "disciplines.vams"
`include "constants.vams"
`define SELFHEAT ((selft < 0.0 || selft == 1.0) && rth > 0.0)  // vbicsetup.c

module vbic_ng(c, b, e, s, t);
    inout c, b, e, s, t;
    electrical c, b, e, s, t;
    electrical cx, ci, bx, bi, ei, bp, si, xf1, xf2;
    parameter real tnom = 27.0;
    parameter real rcx = 0.0;
    parameter real rci = 0.1;
    parameter real vo = 0.0;
    parameter real gamm = 0.0;
    parameter real hrcf = 1.0;
    parameter real rbx = 0.0;
    parameter real rbi = 0.1;
    parameter real re = 0.0;
    parameter real rs = 0.0;
    parameter real rbp = 0.1;
    parameter real is = 1e-16;
    parameter real nf = 1.0;
    parameter real nr = 1.0;
    parameter real fc = 0.9;
    parameter real cbeo = 0.0;
    parameter real cje = 0.0;
    parameter real pe = 0.75;
    parameter real me = 0.33;
    parameter real aje = -0.5;
    parameter real cbco = 0.0;
    parameter real cjc = 0.0;
    parameter real qco = 0.0;
    parameter real cjep = 0.0;
    parameter real pc = 0.75;
    parameter real mc = 0.33;
    parameter real ajc = -0.5;
    parameter real cjcp = 0.0;
    parameter real ps = 0.75;
    parameter real ms = 0.33;
    parameter real ajs = -0.5;
    parameter real ibei = 1e-18;
    parameter real wbe = 1.0;
    parameter real nei = 1.0;
    parameter real iben = 0.0;
    parameter real nen = 2.0;
    parameter real ibci = 1e-16;
    parameter real nci = 1.0;
    parameter real ibcn = 0.0;
    parameter real ncn = 2.0;
    parameter real avc1 = 0.0;
    parameter real avc2 = 0.0;
    parameter real isp = 0.0;
    parameter real wsp = 1.0;
    parameter real nfp = 1.0;
    parameter real ibeip = 0.0;
    parameter real ibenp = 0.0;
    parameter real ibcip = 0.0;
    parameter real ncip = 1.0;
    parameter real ibcnp = 0.0;
    parameter real ncnp = 2.0;
    parameter real vef = 0.0;
    parameter real ver = 0.0;
    parameter real ikf = 0.0;
    parameter real ikr = 0.0;
    parameter real ikp = 0.0;
    parameter real tf = 0.0;
    parameter real qtf = 0.0;
    parameter real xtf = 0.0;
    parameter real vtf = 0.0;
    parameter real itf = 0.0;
    parameter real tr = 0.0;
    parameter real td = 0.0;
    parameter real kfn = 0.0;
    parameter real afn = 1.0;
    parameter real bfn = 1.0;
    parameter real xre = 0.0;
    parameter real xrbi = 0.0;
    parameter real xrci = 0.0;
    parameter real xrs = 0.0;
    parameter real xvo = 0.0;
    parameter real ea = 1.12;
    parameter real eaie = 1.12;
    parameter real eaic = 1.12;
    parameter real eais = 1.12;
    parameter real eane = 1.12;
    parameter real eanc = 1.12;
    parameter real eans = 1.12;
    parameter real xis = 3.0;
    parameter real xii = 3.0;
    parameter real xin = 3.0;
    parameter real tnf = 0.0;
    parameter real tavc = 0.0;
    parameter real rth = 0.0;
    parameter real cth = 0.0;
    parameter real vrt = 0.0;
    parameter real art = 0.1;
    parameter real ccso = 0.0;
    parameter real qbm = 0.0;
    parameter real nkf = 0.5;
    parameter real xikf = 0.0;
    parameter real xrcx = 0.0;
    parameter real xrbx = 0.0;
    parameter real xrbp = 0.0;
    parameter real isrr = 1.0;
    parameter real xisr = 0.0;
    parameter real dear = 0.0;
    parameter real eap = 1.12;
    parameter real vbbe = 0.0;
    parameter real nbbe = 1.0;
    parameter real ibbe = 1e-06;
    parameter real tvbbe1 = 0.0;
    parameter real tvbbe2 = 0.0;
    parameter real tnbbe = 0.0;
    parameter real ebbe = 0.0;
    parameter real dtemp = 0.0;
    parameter real vers = 1.2;
    parameter real vref = 0.0;
    parameter real type = 1.0;                       // +1 NPN, -1 PNP
    parameter real selft = -1.0;                     // self-heating switch (-1: not given)
    (* type="instance" *) parameter real area = 1.0;
    (* type="instance" *) parameter real dtemp_i = 0.0;  // instance DTEMP [K]

    real AVC2atT, CJCPatT, CJCatT, CJEPatT, CJEatT, EBBEatT, GAMMatT, IBCIPatT, IBCIatT, IBCNPatT, IBCNatT, IBEIPatT, IBEIatT, IBENPatT, IBENatT, IHRCF, IIKF, IIKP, IIKR, IITF, IKFatT, ISPatT, ISRRatT, ISatT, IVEF, IVER, IVO, IVTF, Ibc, Ibcj, Ibcp, Ibe, Ibep, Ibex, Iccp, Ifi, Ifp, Igc, Iohm, Irbi, Irbp, Irbx, Irci, Ircx, Ire, Iri, Irp, Irs, Irth, Ith, Itzf, Itzr, Kbci, Kbcx, NBBEatT, NFatT, NRatT, PCatT, PEatT, PSatT, Qbc, Qbco, Qbcp, Qbcx, Qbe, Qbeo, Qbep, Qbex, Qcth, RBIatT, RBPatT, RBXatT, RCIatT, RCXatT, REatT, RSatT, Tdev, Tini, VBBEatT, VOatT, Vtv, argi, argn, argx, avalf, cl, cmx, crt, dT, derf, dv, dv0, dvh, expi, expn, expx, mIf, mv, mv0, p_0, p_1, p_10, p_100, p_101, p_102, p_103, p_104, p_105, p_106, p_107, p_11, p_12, p_13, p_14, p_15, p_16, p_17, p_18, p_19, p_2, p_20, p_21, p_22, p_23, p_24, p_25, p_26, p_27, p_28, p_29, p_3, p_30, p_31, p_32, p_33, p_34, p_35, p_36, p_37, p_38, p_39, p_4, p_40, p_41, p_42, p_43, p_44, p_45, p_46, p_47, p_48, p_49, p_5, p_50, p_51, p_52, p_53, p_54, p_55, p_56, p_57, p_58, p_59, p_6, p_60, p_61, p_62, p_63, p_64, p_65, p_66, p_67, p_68, p_69, p_7, p_70, p_71, p_72, p_73, p_74, p_75, p_76, p_77, p_78, p_79, p_8, p_80, p_81, p_82, p_83, p_84, p_85, p_86, p_87, p_88, p_89, p_9, p_90, p_91, p_92, p_93, p_94, p_95, p_96, p_97, p_98, p_99, psiin, psiio, pwq, q0, q1, q1z, q2, q2p, qb, qbp, qdbc, qdbcp, qdbe, qdbep, qdbex, qhi, ql, qlo, qlo0, rIf, rKp1, rT, sel, sgIf, slTF, tff, vl, vl0, vn, vn0, vnl, vnl0, xvar1, xvar2, xvar3, xvar4, xvar5, xvar6;
    real Vbei, Vbex, Vbci, Vbcx, Vbep, Vrci, Vrbi, Vrbp, Vbcp, Vbe, Vbc, Vrcx, Vrbx, Vre, Vrs, Vrth, Vcei, Vcep;
    real Vxf1, Vxf2, SCALE, gmin, Itxf, Iciei, TAMB;

    analog begin
        gmin = $simparam("gmin", 1e-12);
        TAMB = $temperature - `P_CELSIUS0 + dtemp_i;
        // vbictemp.c: the parameters at the device temperature
        p_5 = hrcf;
        p_14 = fc;
        p_15 = cbeo;
        p_18 = me;
        p_19 = aje;
        p_20 = cbco;
        p_22 = qco;
        p_25 = mc;
        p_26 = ajc;
        p_29 = ms;
        p_30 = ajs;
        p_32 = wbe;
        p_33 = nei;
        p_35 = nen;
        p_37 = nci;
        p_39 = ncn;
        p_40 = avc1;
        p_43 = wsp;
        p_44 = nfp;
        p_48 = ncip;
        p_50 = ncnp;
        p_51 = vef;
        p_52 = ver;
        p_54 = ikr;
        p_55 = ikp;
        p_56 = tf;
        p_57 = qtf;
        p_58 = xtf;
        p_59 = vtf;
        p_60 = itf;
        p_61 = tr;
        p_62 = td;
        p_63 = kfn;
        p_64 = afn;
        p_65 = bfn;
        p_66 = xre;
        p_67 = xrbi;
        p_68 = xrci;
        p_69 = xrs;
        p_70 = xvo;
        p_71 = ea;
        p_72 = eaie;
        p_73 = eaic;
        p_74 = eais;
        p_75 = eane;
        p_76 = eanc;
        p_77 = eans;
        p_78 = xis;
        p_79 = xii;
        p_80 = xin;
        p_81 = tnf;
        p_82 = tavc;
        p_83 = rth;
        p_84 = cth;
        p_85 = vrt;
        p_86 = art;
        p_87 = ccso;
        p_88 = qbm;
        p_89 = nkf;
        p_90 = xikf;
        p_91 = xrcx;
        p_92 = xrbx;
        p_93 = xrbp;
        p_95 = xisr;
        p_96 = dear;
        p_97 = eap;
        p_100 = ibbe;
        p_101 = tvbbe1;
        p_102 = tvbbe2;
        p_103 = tnbbe;
        p_105 = dtemp;
        p_106 = vers;
        p_107 = vref;
        Tini = 2.731500e+02+tnom;
        Tdev = (2.731500e+02+TAMB)+dtemp;
        Vtv = 1.380662e-23*Tdev/1.602189e-19;
        rT = Tdev/Tini;
        dT = Tdev-Tini;
        xvar1 = pow(rT,xikf);
        p_53 = ikf*xvar1;
        xvar1 = pow(rT,xrcx);
        p_1 = rcx*xvar1;
        xvar1 = pow(rT,xrci);
        p_2 = rci*xvar1;
        xvar1 = pow(rT,xrbx);
        p_6 = rbx*xvar1;
        xvar1 = pow(rT,xrbi);
        p_7 = rbi*xvar1;
        xvar1 = pow(rT,xre);
        p_8 = re*xvar1;
        xvar1 = pow(rT,xrs);
        p_9 = rs*xvar1;
        xvar1 = pow(rT,xrbp);
        p_10 = rbp*xvar1;
        xvar2 = pow(rT,xis);
        xvar3 = -ea*(1.0-rT)/Vtv;
        xvar4 = exp(xvar3);
        xvar1 = (xvar2*xvar4);
        xvar5 = (1.0/nf);
        xvar6 = pow(xvar1,xvar5);
        p_11 = is*xvar6;
        xvar2 = pow(rT,xisr);
        xvar3 = -dear*(1.0-rT)/Vtv;
        xvar4 = exp(xvar3);
        xvar1 = (xvar2*xvar4);
        xvar5 = (1.0/nr);
        xvar6 = pow(xvar1,xvar5);
        p_94 = isrr*xvar6;
        xvar2 = pow(rT,xis);
        xvar3 = -eap*(1.0-rT)/Vtv;
        xvar4 = exp(xvar3);
        xvar1 = (xvar2*xvar4);
        xvar5 = (1.0/nfp);
        xvar6 = pow(xvar1,xvar5);
        p_42 = isp*xvar6;
        xvar2 = pow(rT,xii);
        xvar3 = -eaie*(1.0-rT)/Vtv;
        xvar4 = exp(xvar3);
        xvar1 = (xvar2*xvar4);
        xvar5 = (1.0/nei);
        xvar6 = pow(xvar1,xvar5);
        p_31 = ibei*xvar6;
        xvar2 = pow(rT,xin);
        xvar3 = -eane*(1.0-rT)/Vtv;
        xvar4 = exp(xvar3);
        xvar1 = (xvar2*xvar4);
        xvar5 = (1.0/nen);
        xvar6 = pow(xvar1,xvar5);
        p_34 = iben*xvar6;
        xvar2 = pow(rT,xii);
        xvar3 = -eaic*(1.0-rT)/Vtv;
        xvar4 = exp(xvar3);
        xvar1 = (xvar2*xvar4);
        xvar5 = (1.0/nci);
        xvar6 = pow(xvar1,xvar5);
        p_36 = ibci*xvar6;
        xvar2 = pow(rT,xin);
        xvar3 = -eanc*(1.0-rT)/Vtv;
        xvar4 = exp(xvar3);
        xvar1 = (xvar2*xvar4);
        xvar5 = (1.0/ncn);
        xvar6 = pow(xvar1,xvar5);
        p_38 = ibcn*xvar6;
        xvar2 = pow(rT,xii);
        xvar3 = -eaic*(1.0-rT)/Vtv;
        xvar4 = exp(xvar3);
        xvar1 = (xvar2*xvar4);
        xvar5 = (1.0/nci);
        xvar6 = pow(xvar1,xvar5);
        p_45 = ibeip*xvar6;
        xvar2 = pow(rT,xin);
        xvar3 = -eanc*(1.0-rT)/Vtv;
        xvar4 = exp(xvar3);
        xvar1 = (xvar2*xvar4);
        xvar5 = (1.0/ncn);
        xvar6 = pow(xvar1,xvar5);
        p_46 = ibenp*xvar6;
        xvar2 = pow(rT,xii);
        xvar3 = -eais*(1.0-rT)/Vtv;
        xvar4 = exp(xvar3);
        xvar1 = (xvar2*xvar4);
        xvar5 = (1.0/ncip);
        xvar6 = pow(xvar1,xvar5);
        p_47 = ibcip*xvar6;
        xvar2 = pow(rT,xin);
        xvar3 = -eans*(1.0-rT)/Vtv;
        xvar4 = exp(xvar3);
        xvar1 = (xvar2*xvar4);
        xvar5 = (1.0/ncnp);
        xvar6 = pow(xvar1,xvar5);
        p_49 = ibcnp*xvar6;
        p_12 = nf*(1.0+dT*tnf);
        p_13 = nr*(1.0+dT*tnf);
        p_41 = avc2*(1.0+dT*tavc);
        p_98 = vbbe*(1.0+dT*(tvbbe1+dT*tvbbe2));
        p_99 = nbbe*(1.0+dT*tnbbe);
        xvar2 = 0.5*pe*rT/Vtv;
        xvar3 = exp(xvar2);
        xvar4 = -0.5*pe*rT/Vtv;
        xvar5 = exp(xvar4);
        xvar1 = xvar3-xvar5;
        xvar6 = ln(xvar1);
        psiio = 2.0*(Vtv/rT)*xvar6;
        xvar1 = ln(rT);
        psiin = psiio*rT-3.0*Vtv*xvar1-eaie*(rT-1.0);
        xvar2 = -psiin/Vtv;
        xvar3 = exp(xvar2);
        xvar1 = 0.5*(1.0+sqrt(1.0+4.0*xvar3));
        xvar4 = ln(xvar1);
        p_17 = psiin+2.0*Vtv*xvar4;
        xvar2 = 0.5*pc*rT/Vtv;
        xvar3 = exp(xvar2);
        xvar4 = -0.5*pc*rT/Vtv;
        xvar5 = exp(xvar4);
        xvar1 = xvar3-xvar5;
        xvar6 = ln(xvar1);
        psiio = 2.0*(Vtv/rT)*xvar6;
        xvar1 = ln(rT);
        psiin = psiio*rT-3.0*Vtv*xvar1-eaic*(rT-1.0);
        xvar2 = -psiin/Vtv;
        xvar3 = exp(xvar2);
        xvar1 = 0.5*(1.0+sqrt(1.0+4.0*xvar3));
        xvar4 = ln(xvar1);
        p_24 = psiin+2.0*Vtv*xvar4;
        xvar2 = 0.5*ps*rT/Vtv;
        xvar3 = exp(xvar2);
        xvar4 = -0.5*ps*rT/Vtv;
        xvar5 = exp(xvar4);
        xvar1 = xvar3-xvar5;
        xvar6 = ln(xvar1);
        psiio = 2.0*(Vtv/rT)*xvar6;
        xvar1 = ln(rT);
        psiin = psiio*rT-3.0*Vtv*xvar1-eais*(rT-1.0);
        xvar2 = -psiin/Vtv;
        xvar3 = exp(xvar2);
        xvar1 = 0.5*(1.0+sqrt(1.0+4.0*xvar3));
        xvar4 = ln(xvar1);
        p_28 = psiin+2.0*Vtv*xvar4;
        xvar1 = pe/p_17;
        xvar2 = pow(xvar1,me);
        p_16 = cje*xvar2;
        xvar1 = pc/p_24;
        xvar2 = pow(xvar1,mc);
        p_21 = cjc*xvar2;
        xvar1 = pc/p_24;
        xvar2 = pow(xvar1,mc);
        p_23 = cjep*xvar2;
        xvar1 = ps/p_28;
        xvar2 = pow(xvar1,ms);
        p_27 = cjcp*xvar2;
        xvar1 = pow(rT,xis);
        xvar2 = -ea*(1.0-rT)/Vtv;
        xvar3 = exp(xvar2);
        p_4 = gamm*xvar1*xvar3;
        xvar1 = pow(rT,xvo);
        p_3 = vo*xvar1;
        xvar1 = -p_98/(p_99*Vtv);
        p_104 = exp(xvar1);
        p_0 = TAMB+p_105;
        // vbicload.c: p[0] is the device temperature, the mapped values replace the nominal ones
        p_0 = TAMB + dtemp;
        if ($param_given(rth) && p_84 < 1e-12) p_84 = 1e-12;     // vbicsetup.c: cth floor when rth is given
        SCALE = area;

        Vbei = type * V(bi, ei); Vbex = type * V(bx, ei); Vbci = type * V(bi, ci); Vbcx = type * V(bi, cx);
        Vbep = type * V(bx, bp); Vrci = type * V(cx, ci); Vrbi = type * V(bx, bi); Vrbp = type * V(bp, cx);
        Vbcp = type * V(si, bp); Vbe = type * V(b, e); Vbc = type * V(b, c); Vrcx = type * V(c, cx);
        Vrbx = type * V(b, bx); Vre = type * V(e, ei); Vrs = type * V(s, si);
        Vrth = `SELFHEAT ? V(t) : 0.0;
        Vcei = Vbei - Vbci; Vcep = Vbep - Vbcp;
        Vxf1 = V(xf1); Vxf2 = V(xf2);

        Tini = 2.731500e+02+p_0;
        Tdev = (2.731500e+02+p_0)+Vrth;
        Vtv = 1.380662e-23*Tdev/1.602189e-19;
        rT = Tdev/Tini;
        dT = Tdev-Tini;
        xvar1 = pow(rT,p_90);
        IKFatT = p_53*xvar1;
        xvar1 = pow(rT,p_91);
        RCXatT = p_1*xvar1;
        xvar1 = pow(rT,p_68);
        RCIatT = p_2*xvar1;
        xvar1 = pow(rT,p_92);
        RBXatT = p_6*xvar1;
        xvar1 = pow(rT,p_67);
        RBIatT = p_7*xvar1;
        xvar1 = pow(rT,p_66);
        REatT = p_8*xvar1;
        xvar1 = pow(rT,p_69);
        RSatT = p_9*xvar1;
        xvar1 = pow(rT,p_93);
        RBPatT = p_10*xvar1;
        xvar2 = pow(rT,p_78);
        xvar3 = -p_71*(1.0-rT)/Vtv;
        xvar4 = exp(xvar3);
        xvar1 = (xvar2*xvar4);
        xvar5 = (1.0/p_12);
        xvar6 = pow(xvar1,xvar5);
        ISatT = p_11*xvar6;
        xvar2 = pow(rT,p_95);
        xvar3 = -p_96*(1.0-rT)/Vtv;
        xvar4 = exp(xvar3);
        xvar1 = (xvar2*xvar4);
        xvar5 = (1.0/p_13);
        xvar6 = pow(xvar1,xvar5);
        ISRRatT = p_94*xvar6;
        xvar2 = pow(rT,p_78);
        xvar3 = -p_97*(1.0-rT)/Vtv;
        xvar4 = exp(xvar3);
        xvar1 = (xvar2*xvar4);
        xvar5 = (1.0/p_44);
        xvar6 = pow(xvar1,xvar5);
        ISPatT = p_42*xvar6;
        xvar2 = pow(rT,p_79);
        xvar3 = -p_72*(1.0-rT)/Vtv;
        xvar4 = exp(xvar3);
        xvar1 = (xvar2*xvar4);
        xvar5 = (1.0/p_33);
        xvar6 = pow(xvar1,xvar5);
        IBEIatT = p_31*xvar6;
        xvar2 = pow(rT,p_80);
        xvar3 = -p_75*(1.0-rT)/Vtv;
        xvar4 = exp(xvar3);
        xvar1 = (xvar2*xvar4);
        xvar5 = (1.0/p_35);
        xvar6 = pow(xvar1,xvar5);
        IBENatT = p_34*xvar6;
        xvar2 = pow(rT,p_79);
        xvar3 = -p_73*(1.0-rT)/Vtv;
        xvar4 = exp(xvar3);
        xvar1 = (xvar2*xvar4);
        xvar5 = (1.0/p_37);
        xvar6 = pow(xvar1,xvar5);
        IBCIatT = p_36*xvar6;
        xvar2 = pow(rT,p_80);
        xvar3 = -p_76*(1.0-rT)/Vtv;
        xvar4 = exp(xvar3);
        xvar1 = (xvar2*xvar4);
        xvar5 = (1.0/p_39);
        xvar6 = pow(xvar1,xvar5);
        IBCNatT = p_38*xvar6;
        xvar2 = pow(rT,p_79);
        xvar3 = -p_73*(1.0-rT)/Vtv;
        xvar4 = exp(xvar3);
        xvar1 = (xvar2*xvar4);
        xvar5 = (1.0/p_37);
        xvar6 = pow(xvar1,xvar5);
        IBEIPatT = p_45*xvar6;
        xvar2 = pow(rT,p_80);
        xvar3 = -p_76*(1.0-rT)/Vtv;
        xvar4 = exp(xvar3);
        xvar1 = (xvar2*xvar4);
        xvar5 = (1.0/p_39);
        xvar6 = pow(xvar1,xvar5);
        IBENPatT = p_46*xvar6;
        xvar2 = pow(rT,p_79);
        xvar3 = -p_74*(1.0-rT)/Vtv;
        xvar4 = exp(xvar3);
        xvar1 = (xvar2*xvar4);
        xvar5 = (1.0/p_48);
        xvar6 = pow(xvar1,xvar5);
        IBCIPatT = p_47*xvar6;
        xvar2 = pow(rT,p_80);
        xvar3 = -p_77*(1.0-rT)/Vtv;
        xvar4 = exp(xvar3);
        xvar1 = (xvar2*xvar4);
        xvar5 = (1.0/p_50);
        xvar6 = pow(xvar1,xvar5);
        IBCNPatT = p_49*xvar6;
        NFatT = p_12*(1.0+dT*p_81);
        NRatT = p_13*(1.0+dT*p_81);
        AVC2atT = p_41*(1.0+dT*p_82);
        VBBEatT = p_98*(1.0+dT*(p_101+dT*p_102));
        NBBEatT = p_99*(1.0+dT*p_103);
        xvar2 = 0.5*p_17*rT/Vtv;
        xvar3 = exp(xvar2);
        xvar4 = -0.5*p_17*rT/Vtv;
        xvar5 = exp(xvar4);
        xvar1 = xvar3-xvar5;
        xvar6 = ln(xvar1);
        psiio = 2.0*(Vtv/rT)*xvar6;
        xvar1 = ln(rT);
        psiin = psiio*rT-3.0*Vtv*xvar1-p_72*(rT-1.0);
        xvar2 = -psiin/Vtv;
        xvar3 = exp(xvar2);
        xvar1 = 0.5*(1.0+sqrt(1.0+4.0*xvar3));
        xvar4 = ln(xvar1);
        PEatT = psiin+2.0*Vtv*xvar4;
        xvar2 = 0.5*p_24*rT/Vtv;
        xvar3 = exp(xvar2);
        xvar4 = -0.5*p_24*rT/Vtv;
        xvar5 = exp(xvar4);
        xvar1 = xvar3-xvar5;
        xvar6 = ln(xvar1);
        psiio = 2.0*(Vtv/rT)*xvar6;
        xvar1 = ln(rT);
        psiin = psiio*rT-3.0*Vtv*xvar1-p_73*(rT-1.0);
        xvar2 = -psiin/Vtv;
        xvar3 = exp(xvar2);
        xvar1 = 0.5*(1.0+sqrt(1.0+4.0*xvar3));
        xvar4 = ln(xvar1);
        PCatT = psiin+2.0*Vtv*xvar4;
        xvar2 = 0.5*p_28*rT/Vtv;
        xvar3 = exp(xvar2);
        xvar4 = -0.5*p_28*rT/Vtv;
        xvar5 = exp(xvar4);
        xvar1 = xvar3-xvar5;
        xvar6 = ln(xvar1);
        psiio = 2.0*(Vtv/rT)*xvar6;
        xvar1 = ln(rT);
        psiin = psiio*rT-3.0*Vtv*xvar1-p_74*(rT-1.0);
        xvar2 = -psiin/Vtv;
        xvar3 = exp(xvar2);
        xvar1 = 0.5*(1.0+sqrt(1.0+4.0*xvar3));
        xvar4 = ln(xvar1);
        PSatT = psiin+2.0*Vtv*xvar4;
        xvar1 = p_17/PEatT;
        xvar2 = pow(xvar1,p_18);
        CJEatT = p_16*xvar2;
        xvar1 = p_24/PCatT;
        xvar2 = pow(xvar1,p_25);
        CJCatT = p_21*xvar2;
        xvar1 = p_24/PCatT;
        xvar2 = pow(xvar1,p_25);
        CJEPatT = p_23*xvar2;
        xvar1 = p_28/PSatT;
        xvar2 = pow(xvar1,p_29);
        CJCPatT = p_27*xvar2;
        xvar1 = pow(rT,p_78);
        xvar2 = -p_71*(1.0-rT)/Vtv;
        xvar3 = exp(xvar2);
        GAMMatT = p_4*xvar1*xvar3;
        xvar1 = pow(rT,p_70);
        VOatT = p_3*xvar1;
        xvar1 = -VBBEatT/(NBBEatT*Vtv);
        EBBEatT = exp(xvar1);
        if (p_51>0.0) begin
        IVEF = 1.0/p_51;
        end else begin
        IVEF = 0.0;
        end
        if (p_52>0.0) begin
        IVER = 1.0/p_52;
        end else begin
        IVER = 0.0;
        end
        if (p_53>0.0) begin
        IIKF = 1.0/IKFatT;
        end else begin
        IIKF = 0.0;
        end
        if (p_54>0.0) begin
        IIKR = 1.0/p_54;
        end else begin
        IIKR = 0.0;
        end
        if (p_55>0.0) begin
        IIKP = 1.0/p_55;
        end else begin
        IIKP = 0.0;
        end
        if (p_3>0.0) begin
        IVO = 1.0/VOatT;
        end else begin
        IVO = 0.0;
        end
        if (p_5>0.0) begin
        IHRCF = 1.0/p_5;
        end else begin
        IHRCF = 0.0;
        end
        if (p_59>0.0) begin
        IVTF = 1.0/p_59;
        end else begin
        IVTF = 0.0;
        end
        if (p_60>0.0) begin
        IITF = 1.0/p_60;
        end else begin
        IITF = 0.0;
        end
        if (p_60>0.0) begin
        slTF = 0.0;
        end else begin
        slTF = 1.0;
        end
        dv0 = -PEatT*p_14;
        if (p_19<=0.0) begin
        dvh = Vbei+dv0;
        if (dvh>0.0) begin
        xvar1 = (1.0-p_14);
        xvar2 = (-1.0-p_18);
        pwq = pow(xvar1,xvar2);
        qlo = PEatT*(1.0-pwq*(1.0-p_14)*(1.0-p_14))/(1.0-p_18);
        qhi = dvh*(1.0-p_14+0.5*p_18*dvh/PEatT)*pwq;
        end else begin
        xvar1 = (1.0-Vbei/PEatT);
        xvar2 = (1.0-p_18);
        xvar3 = pow(xvar1,xvar2);
        qlo = PEatT*(1.0-xvar3)/(1.0-p_18);
        qhi = 0.0;
        end
        qdbe = qlo+qhi;
        end else begin
        mv0 = sqrt(dv0*dv0+4.0*p_19*p_19);
        vl0 = -0.5*(dv0+mv0);
        xvar1 = (1.0-vl0/PEatT);
        xvar2 = (1.0-p_18);
        xvar3 = pow(xvar1,xvar2);
        q0 = -PEatT*xvar3/(1.0-p_18);
        dv = Vbei+dv0;
        mv = sqrt(dv*dv+4.0*p_19*p_19);
        vl = 0.5*(dv-mv)-dv0;
        xvar1 = (1.0-vl/PEatT);
        xvar2 = (1.0-p_18);
        xvar3 = pow(xvar1,xvar2);
        qlo = -PEatT*xvar3/(1.0-p_18);
        xvar1 = (1.0-p_14);
        xvar2 = (-p_18);
        xvar3 = pow(xvar1,xvar2);
        qdbe = qlo+xvar3*(Vbei-vl+vl0)-q0;
        end
        dv0 = -PEatT*p_14;
        if (p_19<=0.0) begin
        dvh = Vbex+dv0;
        if (dvh>0.0) begin
        xvar1 = (1.0-p_14);
        xvar2 = (-1.0-p_18);
        pwq = pow(xvar1,xvar2);
        qlo = PEatT*(1.0-pwq*(1.0-p_14)*(1.0-p_14))/(1.0-p_18);
        qhi = dvh*(1.0-p_14+0.5*p_18*dvh/PEatT)*pwq;
        end else begin
        xvar1 = (1.0-Vbex/PEatT);
        xvar2 = (1.0-p_18);
        xvar3 = pow(xvar1,xvar2);
        qlo = PEatT*(1.0-xvar3)/(1.0-p_18);
        qhi = 0.0;
        end
        qdbex = qlo+qhi;
        end else begin
        mv0 = sqrt(dv0*dv0+4.0*p_19*p_19);
        vl0 = -0.5*(dv0+mv0);
        xvar1 = (1.0-vl0/PEatT);
        xvar2 = (1.0-p_18);
        xvar3 = pow(xvar1,xvar2);
        q0 = -PEatT*xvar3/(1.0-p_18);
        dv = Vbex+dv0;
        mv = sqrt(dv*dv+4.0*p_19*p_19);
        vl = 0.5*(dv-mv)-dv0;
        xvar1 = (1.0-vl/PEatT);
        xvar2 = (1.0-p_18);
        xvar3 = pow(xvar1,xvar2);
        qlo = -PEatT*xvar3/(1.0-p_18);
        xvar1 = (1.0-p_14);
        xvar2 = (-p_18);
        xvar3 = pow(xvar1,xvar2);
        qdbex = qlo+xvar3*(Vbex-vl+vl0)-q0;
        end
        dv0 = -PCatT*p_14;
        if (p_26<=0.0) begin
        dvh = Vbci+dv0;
        if (dvh>0.0) begin
        xvar1 = (1.0-p_14);
        xvar2 = (-1.0-p_25);
        pwq = pow(xvar1,xvar2);
        qlo = PCatT*(1.0-pwq*(1.0-p_14)*(1.0-p_14))/(1.0-p_25);
        qhi = dvh*(1.0-p_14+0.5*p_25*dvh/PCatT)*pwq;
        end else begin
        if ((p_85>0.0)&&(Vbci<-p_85)) begin
        xvar1 = (1.0+p_85/PCatT);
        xvar2 = (1.0-p_25);
        xvar3 = pow(xvar1,xvar2);
        qlo = PCatT*(1.0-xvar3*(1.0-((1.0-p_25)*(Vbci+p_85))/(PCatT+p_85)))/(1.0-p_25);
        end else begin
        xvar1 = (1.0-Vbci/PCatT);
        xvar2 = (1.0-p_25);
        xvar3 = pow(xvar1,xvar2);
        qlo = PCatT*(1.0-xvar3)/(1.0-p_25);
        end
        qhi = 0.0;
        end
        qdbc = qlo+qhi;
        end else begin
        if ((p_85>0.0)&&(p_86>0.0)) begin
        vn0 = (p_85+dv0)/(p_85-dv0);
        vnl0 = 2.0*vn0/(sqrt((vn0-1.0)*(vn0-1.0)+4.0*p_26*p_26)+sqrt((vn0+1.0)*(vn0+1.0)+4.0*p_86*p_86));
        vl0 = 0.5*(vnl0*(p_85-dv0)-p_85-dv0);
        xvar1 = (1.0-vl0/PCatT);
        xvar2 = (1.0-p_25);
        xvar3 = pow(xvar1,xvar2);
        qlo0 = PCatT*(1.0-xvar3)/(1.0-p_25);
        vn = (2.0*Vbci+p_85+dv0)/(p_85-dv0);
        vnl = 2.0*vn/(sqrt((vn-1.0)*(vn-1.0)+4.0*p_26*p_26)+sqrt((vn+1.0)*(vn+1.0)+4.0*p_86*p_86));
        vl = 0.5*(vnl*(p_85-dv0)-p_85-dv0);
        xvar1 = (1.0-vl/PCatT);
        xvar2 = (1.0-p_25);
        xvar3 = pow(xvar1,xvar2);
        qlo = PCatT*(1.0-xvar3)/(1.0-p_25);
        sel = 0.5*(vnl+1.0);
        xvar1 = (1.0+p_85/PCatT);
        xvar2 = (-p_25);
        crt = pow(xvar1,xvar2);
        xvar1 = (1.0+dv0/PCatT);
        xvar2 = (-p_25);
        cmx = pow(xvar1,xvar2);
        cl = (1.0-sel)*crt+sel*cmx;
        ql = (Vbci-vl+vl0)*cl;
        qdbc = ql+qlo-qlo0;
        end else begin
        mv0 = sqrt(dv0*dv0+4.0*p_26*p_26);
        vl0 = -0.5*(dv0+mv0);
        xvar1 = (1.0-vl0/PCatT);
        xvar2 = (1.0-p_25);
        xvar3 = pow(xvar1,xvar2);
        q0 = -PCatT*xvar3/(1.0-p_25);
        dv = Vbci+dv0;
        mv = sqrt(dv*dv+4.0*p_26*p_26);
        vl = 0.5*(dv-mv)-dv0;
        xvar1 = (1.0-vl/PCatT);
        xvar2 = (1.0-p_25);
        xvar3 = pow(xvar1,xvar2);
        qlo = -PCatT*xvar3/(1.0-p_25);
        xvar1 = (1.0-p_14);
        xvar2 = (-p_25);
        xvar3 = pow(xvar1,xvar2);
        qdbc = qlo+xvar3*(Vbci-vl+vl0)-q0;
        end
        end
        dv0 = -PCatT*p_14;
        if (p_26<=0.0) begin
        dvh = Vbep+dv0;
        if (dvh>0.0) begin
        xvar1 = (1.0-p_14);
        xvar2 = (-1.0-p_25);
        pwq = pow(xvar1,xvar2);
        qlo = PCatT*(1.0-pwq*(1.0-p_14)*(1.0-p_14))/(1.0-p_25);
        qhi = dvh*(1.0-p_14+0.5*p_25*dvh/PCatT)*pwq;
        end else begin
        if ((p_85>0.0)&&(Vbep<-p_85)) begin
        xvar1 = (1.0+p_85/PCatT);
        xvar2 = (1.0-p_25);
        xvar3 = pow(xvar1,xvar2);
        qlo = PCatT*(1.0-xvar3*(1.0-((1.0-p_25)*(Vbep+p_85))/(PCatT+p_85)))/(1.0-p_25);
        end else begin
        xvar1 = (1.0-Vbep/PCatT);
        xvar2 = (1.0-p_25);
        xvar3 = pow(xvar1,xvar2);
        qlo = PCatT*(1.0-xvar3)/(1.0-p_25);
        end
        qhi = 0.0;
        end
        qdbep = qlo+qhi;
        end else begin
        if ((p_85>0.0)&&(p_86>0.0)) begin
        vn0 = (p_85+dv0)/(p_85-dv0);
        vnl0 = 2.0*vn0/(sqrt((vn0-1.0)*(vn0-1.0)+4.0*p_26*p_26)+sqrt((vn0+1.0)*(vn0+1.0)+4.0*p_86*p_86));
        vl0 = 0.5*(vnl0*(p_85-dv0)-p_85-dv0);
        xvar1 = (1.0-vl0/PCatT);
        xvar2 = (1.0-p_25);
        xvar3 = pow(xvar1,xvar2);
        qlo0 = PCatT*(1.0-xvar3)/(1.0-p_25);
        vn = (2.0*Vbep+p_85+dv0)/(p_85-dv0);
        vnl = 2.0*vn/(sqrt((vn-1.0)*(vn-1.0)+4.0*p_26*p_26)+sqrt((vn+1.0)*(vn+1.0)+4.0*p_86*p_86));
        vl = 0.5*(vnl*(p_85-dv0)-p_85-dv0);
        xvar1 = (1.0-vl/PCatT);
        xvar2 = (1.0-p_25);
        xvar3 = pow(xvar1,xvar2);
        qlo = PCatT*(1.0-xvar3)/(1.0-p_25);
        sel = 0.5*(vnl+1.0);
        xvar1 = (1.0+p_85/PCatT);
        xvar2 = (-p_25);
        crt = pow(xvar1,xvar2);
        xvar1 = (1.0+dv0/PCatT);
        xvar2 = (-p_25);
        cmx = pow(xvar1,xvar2);
        cl = (1.0-sel)*crt+sel*cmx;
        ql = (Vbep-vl+vl0)*cl;
        qdbep = ql+qlo-qlo0;
        end else begin
        mv0 = sqrt(dv0*dv0+4.0*p_26*p_26);
        vl0 = -0.5*(dv0+mv0);
        xvar1 = (1.0-vl0/PCatT);
        xvar2 = (1.0-p_25);
        xvar3 = pow(xvar1,xvar2);
        q0 = -PCatT*xvar3/(1.0-p_25);
        dv = Vbep+dv0;
        mv = sqrt(dv*dv+4.0*p_26*p_26);
        vl = 0.5*(dv-mv)-dv0;
        xvar1 = (1.0-vl/PCatT);
        xvar2 = (1.0-p_25);
        xvar3 = pow(xvar1,xvar2);
        qlo = -PCatT*xvar3/(1.0-p_25);
        xvar1 = (1.0-p_14);
        xvar2 = (-p_25);
        xvar3 = pow(xvar1,xvar2);
        qdbep = qlo+xvar3*(Vbep-vl+vl0)-q0;
        end
        end
        if (p_27>0.0) begin
        dv0 = -PSatT*p_14;
        if (p_30<=0.0) begin
        dvh = Vbcp+dv0;
        if (dvh>0.0) begin
        xvar1 = (1.0-p_14);
        xvar2 = (-1.0-p_29);
        pwq = pow(xvar1,xvar2);
        qlo = PSatT*(1.0-pwq*(1.0-p_14)*(1.0-p_14))/(1.0-p_29);
        qhi = dvh*(1.0-p_14+0.5*p_29*dvh/PSatT)*pwq;
        end else begin
        xvar1 = (1.0-Vbcp/PSatT);
        xvar2 = (1.0-p_29);
        xvar3 = pow(xvar1,xvar2);
        qlo = PSatT*(1.0-xvar3)/(1.0-p_29);
        qhi = 0.0;
        end
        qdbcp = qlo+qhi;
        end else begin
        mv0 = sqrt(dv0*dv0+4.0*p_30*p_30);
        vl0 = -0.5*(dv0+mv0);
        xvar1 = (1.0-vl0/PSatT);
        xvar2 = (1.0-p_29);
        xvar3 = pow(xvar1,xvar2);
        q0 = -PSatT*xvar3/(1.0-p_29);
        dv = Vbcp+dv0;
        mv = sqrt(dv*dv+4.0*p_30*p_30);
        vl = 0.5*(dv-mv)-dv0;
        xvar1 = (1.0-vl/PSatT);
        xvar2 = (1.0-p_29);
        xvar3 = pow(xvar1,xvar2);
        qlo = -PSatT*xvar3/(1.0-p_29);
        xvar1 = (1.0-p_14);
        xvar2 = (-p_29);
        xvar3 = pow(xvar1,xvar2);
        qdbcp = qlo+xvar3*(Vbcp-vl+vl0)-q0;
        end
        end else begin
        qdbcp = 0.0;
        end
        argi = Vbei/(NFatT*Vtv);
        expi = exp(argi);
        Ifi = ISatT*(expi-1.0);
        argi = Vbci/(NRatT*Vtv);
        expi = exp(argi);
        Iri = ISatT*ISRRatT*(expi-1.0);
        q1z = 1.0+qdbe*IVER+qdbc*IVEF;
        q1 = 0.5*(sqrt((q1z-1.0e-4)*(q1z-1.0e-4)+1.0e-8)+q1z-1.0e-4)+1.0e-4;
        q2 = Ifi*IIKF+Iri*IIKR;
        if (p_88<0.5) begin
        xvar2 = 1.0/p_89;
        xvar3 = pow(q1,xvar2);
        xvar1 = (xvar3+4.0*q2);
        xvar4 = pow(xvar1,p_89);
        qb = 0.5*(q1+xvar4);
        end else begin
        xvar1 = (1.0+4.0*q2);
        xvar2 = pow(xvar1,p_89);
        qb = 0.5*q1*(1.0+xvar2);
        end
        Itzr = Iri/qb;
        Itzf = Ifi/qb;
        if (p_42>0.0) begin
        argi = Vbep/(p_44*Vtv);
        expi = exp(argi);
        argx = Vbci/(p_44*Vtv);
        expx = exp(argx);
        Ifp = ISPatT*(p_43*expi+(1.0-p_43)*expx-1.0);
        q2p = Ifp*IIKP;
        qbp = 0.5*(1.0+sqrt(1.0+4.0*q2p));
        argi = Vbcp/(p_44*Vtv);
        expi = exp(argi);
        Irp = ISPatT*(expi-1.0);
        Iccp = (Ifp-Irp)/qbp;
        end else begin
        Ifp = 0.0;
        qbp = 1.0;
        Iccp = 0.0;
        end
        if (p_32==1.0) begin
        argi = Vbei/(p_33*Vtv);
        expi = exp(argi);
        argn = Vbei/(p_35*Vtv);
        expn = exp(argn);
        if (p_98>0.0) begin
        argx = (-VBBEatT-Vbei)/(NBBEatT*Vtv);
        expx = exp(argx);
        Ibe = IBEIatT*(expi-1.0)+IBENatT*(expn-1.0)-p_100*(expx-EBBEatT);
        end else begin
        Ibe = IBEIatT*(expi-1.0)+IBENatT*(expn-1.0);
        end
        Ibex = 0.0;
        end else if (p_32==0.0) begin
        Ibe = 0.0;
        argi = Vbex/(p_33*Vtv);
        expi = exp(argi);
        argn = Vbex/(p_35*Vtv);
        expn = exp(argn);
        if (p_98>0.0) begin
        argx = (-VBBEatT-Vbex)/(NBBEatT*Vtv);
        expx = exp(argx);
        Ibex = IBEIatT*(expi-1.0)+IBENatT*(expn-1.0)-p_100*(expx-EBBEatT);
        end else begin
        Ibex = IBEIatT*(expi-1.0)+IBENatT*(expn-1.0);
        end
        end else begin
        argi = Vbei/(p_33*Vtv);
        expi = exp(argi);
        argn = Vbei/(p_35*Vtv);
        expn = exp(argn);
        if (p_98>0.0) begin
        argx = (-VBBEatT-Vbei)/(NBBEatT*Vtv);
        expx = exp(argx);
        Ibe = p_32*(IBEIatT*(expi-1.0)+IBENatT*(expn-1.0)-p_100*(expx-EBBEatT));
        end else begin
        Ibe = p_32*(IBEIatT*(expi-1.0)+IBENatT*(expn-1.0));
        end
        argi = Vbex/(p_33*Vtv);
        expi = exp(argi);
        argn = Vbex/(p_35*Vtv);
        expn = exp(argn);
        if (p_98>0.0) begin
        argx = (-VBBEatT-Vbex)/(NBBEatT*Vtv);
        expx = exp(argx);
        Ibex = (1.0-p_32)*(IBEIatT*(expi-1.0)+IBENatT*(expn-1.0)-p_100*(expx-EBBEatT));
        end else begin
        Ibex = (1.0-p_32)*(IBEIatT*(expi-1.0)+IBENatT*(expn-1.0));
        end
        end
        argi = Vbci/(p_37*Vtv);
        expi = exp(argi);
        argn = Vbci/(p_39*Vtv);
        expn = exp(argn);
        Ibcj = IBCIatT*(expi-1.0)+IBCNatT*(expn-1.0);
        if ((p_45>0.0)||(p_46>0.0)) begin
        argi = Vbep/(p_37*Vtv);
        expi = exp(argi);
        argn = Vbep/(p_39*Vtv);
        expn = exp(argn);
        Ibep = IBEIPatT*(expi-1.0)+IBENPatT*(expn-1.0);
        end else begin
        Ibep = 0.0;
        end
        if (p_40>0.0) begin
        vl = 0.5*(sqrt((PCatT-Vbci)*(PCatT-Vbci)+0.01)+(PCatT-Vbci));
        xvar2 = (p_25-1.0);
        xvar3 = pow(vl,xvar2);
        xvar1 = -AVC2atT*xvar3;
        xvar4 = exp(xvar1);
        avalf = p_40*vl*xvar4;
        Igc = (Itzf-Itzr-Ibcj)*avalf;
        end else begin
        Igc = 0.0;
        end
        Ibc = Ibcj-Igc;
        if (p_1>0.0) begin
        Ircx = Vrcx/RCXatT;
        end else begin
        Ircx = 0.0;
        end
        argi = Vbci/Vtv;
        expi = exp(argi);
        argx = Vbcx/Vtv;
        expx = exp(argx);
        Kbci = sqrt(1.0+GAMMatT*expi);
        Kbcx = sqrt(1.0+GAMMatT*expx);
        if (p_2>0.0) begin
        rKp1 = (Kbci+1.0)/(Kbcx+1.0);
        xvar1 = ln(rKp1);
        Iohm = (Vrci+Vtv*(Kbci-Kbcx-xvar1))/RCIatT;
        derf = IVO*RCIatT*Iohm/(1.0+0.5*IVO*IHRCF*sqrt(Vrci*Vrci+0.01));
        Irci = Iohm/sqrt(1.0+derf*derf);
        end else begin
        Irci = 0.0;
        end
        if (p_6>0.0) begin
        Irbx = Vrbx/RBXatT;
        end else begin
        Irbx = 0.0;
        end
        if (p_7>0.0) begin
        Irbi = Vrbi*qb/RBIatT;
        end else begin
        Irbi = 0.0;
        end
        if (p_8>0.0) begin
        Ire = Vre/REatT;
        end else begin
        Ire = 0.0;
        end
        if (p_10>0.0) begin
        Irbp = Vrbp*qbp/RBPatT;
        end else begin
        Irbp = 0.0;
        end
        if ((p_47>0.0)||(p_49>0.0)) begin
        argi = Vbcp/(p_48*Vtv);
        expi = exp(argi);
        argn = Vbcp/(p_50*Vtv);
        expn = exp(argn);
        Ibcp = IBCIPatT*(expi-1.0)+IBCNPatT*(expn-1.0);
        end else begin
        Ibcp = 0.0;
        end
        if (p_9>0.0) begin
        Irs = Vrs/RSatT;
        end else begin
        Irs = 0.0;
        end
        if (Ifi>0.0) begin
        sgIf = 1.0;
        end else begin
        sgIf = 0.0;
        end
        rIf = Ifi*sgIf*IITF;
        mIf = rIf/(rIf+1.0);
        xvar1 = Vbci*IVTF/1.44;
        xvar2 = exp(xvar1);
        tff = p_56*(1.0+p_57*q1)*(1.0+p_58*xvar2*(slTF+mIf*mIf)*sgIf);
        Qbe = CJEatT*qdbe*p_32+tff*Ifi/qb;
        Qbex = CJEatT*qdbex*(1.0-p_32);
        Qbc = CJCatT*qdbc+p_61*Iri+p_22*Kbci;
        Qbcx = p_22*Kbcx;
        Qbep = CJEPatT*qdbep+p_61*Ifp;
        Qbcp = CJCPatT*qdbcp+p_87*Vbcp;
        Qbeo = Vbe*p_15;
        Qbco = Vbc*p_20;
        Ith = -(Ibe*Vbei+Ibc*Vbci+(Itzf-Itzr)*Vcei+Ibex*Vbex+Ibep*Vbep+Irs*Vrs+Ibcp*Vbcp+Iccp*Vcep+Ircx*Vrcx+Irci*Vrci+Irbx*Vrbx+Irbi*Vrbi+Ire*Vre+Irbp*Vrbp);
        if (p_83>0.0) begin
        Irth = Vrth/p_83;
        end else begin
        Irth = 0.0;
        end
        Qcth = Vrth*p_84;
        if (SCALE!=1.0) begin
        Ibe = SCALE*Ibe;
        Ibex = SCALE*Ibex;
        Itzf = SCALE*Itzf;
        Itzr = SCALE*Itzr;
        Ibc = SCALE*Ibc;
        Ibep = SCALE*Ibep;
        Ircx = SCALE*Ircx;
        Irci = SCALE*Irci;
        Irbx = SCALE*Irbx;
        Irbi = SCALE*Irbi;
        Ire = SCALE*Ire;
        Irbp = SCALE*Irbp;
        Qbe = SCALE*Qbe;
        Qbex = SCALE*Qbex;
        Qbc = SCALE*Qbc;
        Qbcx = SCALE*Qbcx;
        Qbep = SCALE*Qbep;
        Qbeo = SCALE*Qbeo;
        Qbco = SCALE*Qbco;
        Ibcp = SCALE*Ibcp;
        Iccp = SCALE*Iccp;
        Irs = SCALE*Irs;
        Qbcp = SCALE*Qbcp;
        Irth = SCALE*Irth;
        Ith = SCALE*Ith;
        Qcth = SCALE*Qcth;
        end

        // excess phase (TD): Itzf through a 2-pole delay network on xf1, xf2 (vbicload.c)
        if (td > 0.0) begin  // vbicsetup.c: excess phase
            I(xf1) <+ Vxf2 - Itzf + ddt(td * Vxf1);
            I(xf2) <+ Vxf2 - Vxf1 + ddt(td * Vxf2 / 3.0);
            Itxf = Vxf2;
        end else begin
            I(xf1) <+ Vxf1;
            I(xf2) <+ Vxf2;
            Itxf = Itzf;
        end
        Iciei = Itxf - Itzr;

        I(bi, ei) <+ type * (Ibe + gmin * Vbei + ddt(Qbe));
        I(bx, ei) <+ type * (Ibex + gmin * Vbex + ddt(Qbex));
        I(ci, ei) <+ type * Iciei;
        I(bi, ci) <+ type * (Ibc + gmin * Vbci + ddt(Qbc));
        I(bi, cx) <+ type * ddt(Qbcx);
        I(bx, bp) <+ type * (Ibep + gmin * Vbep + ddt(Qbep));
        I(cx, ci) <+ type * (Irci + gmin * (Vrci + Vbci + Vbcx));
        I(bx, bi) <+ type * Irbi;
        I(bp, cx) <+ type * Irbp;
        I(si, bp) <+ type * (Ibcp + gmin * Vbcp + ddt(Qbcp));
        I(bx, si) <+ type * Iccp;
        I(b, e) <+ type * ddt(Qbeo);
        I(b, c) <+ type * ddt(Qbco);
        if (rcx > 0.0) I(c, cx) <+ type * Ircx; else V(c, cx) <+ 0.0;
        if (rbx > 0.0) I(b, bx) <+ type * Irbx; else V(b, bx) <+ 0.0;
        if (re > 0.0) I(e, ei) <+ type * Ire; else V(e, ei) <+ 0.0;
        if (rs > 0.0) I(s, si) <+ type * Irs; else V(s, si) <+ 0.0;
        // Ith is minus the dissipated power: VBICload injects -Ith into the thermal node. Without self-heating
        // nothing in the model loads it (ngspice: v(t) = 0); a GMIN keeps a floating t from leaving AC singular.
        if (`SELFHEAT) I(t) <+ Irth + Ith + ddt(Qcth); else I(t) <+ gmin * V(t);
    end
endmodule
