* BJT temperature coefficients (TLEV 0) at -30 and 110 C: TBF1/2, TBR1, TVAF1, TIKF1, TRB1, TRC, TRE1, TRM1, TNF1, TNE1, TNC1,
* TMJE1, TTF1, TITF1; TREF for TNOM; C2 / C4 for ISE / ISC
VCC c0 0 DC 5
VB b0 0 DC 0.7
RB b0 b 1k
RC c0 c 500
Q1 c b 0 qt
.model qt NPN(IS=2e-16 BF=150 BR=3 NF=1.01 NR=1.02 VAF=60 VAR=15 IKF=20m IKR=5m C2=5e-14 NE=1.6 C4=1e-13 NC=1.9
+ RB=40 RBM=10 IRB=1m RC=5 RE=1 CJE=1p MJE=0.35 CJC=0.5p TF=50p ITF=10m XTF=2 VTF=3 XTB=1.5 EG=1.12 XTI=3.2 TREF=30
+ TBF1=2e-3 TBF2=1e-6 TBR1=1e-3 TVAF1=-1e-3 TIKF1=-2e-3 TRB1=3e-3 TRC=2e-3 TRE1=1e-3 TRM1=2e-3 TNF1=1e-4 TNE1=2e-4 TNC1=1e-4
+ TMJE1=1e-3 TTF1=2e-3 TITF1=1e-3)
.temp -30 110
.dc VB 0.4 1.0 0.01 VCC 1 5 4
.end
