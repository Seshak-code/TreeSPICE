B sources: V= and I= over node voltages, DC sweep
* Thresholds sit between sweep points: at a point, the side a comparison falls on is rounding (in ngspice too)
V1 a 0 DC 0
V2 b 0 DC 0.4
R0 a 0 1k
R00 b 0 1k
B1 o1 0 V=V(a)*2+V(b)
R1 o1 0 1k
B2 o2 0 I=-V(a,b)/1k
R2 o2 0 2k
B3 o3 0 V=V(a)>0.55 ? 3 : -3
R3 o3 0 1k
B4 o4 0 V=pwr(V(a)-1,2)+sqrt(abs(V(b)))+exp(V(a)/2)-ln(1+V(a)*V(a))
R4 o4 0 1k
B5 o5 0 V=min(V(a),0.6)+max(V(b),V(a))
R5 o5 0 1k
B6 o6 0 I=atan(V(a))-sinh(V(b))+tanh(V(a))*cosh(V(b))+u(V(a)-0.55)+uramp(V(a)-0.3)
R6 o6 0 100
.dc V1 0 1 0.1
.end
