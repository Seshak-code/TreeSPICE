* IHP SG13G2 npn13G2 HBT: output characteristics, Nx=2 (self-heating)
* ngspice's default tolerances stop its self-heated Newton 0.15 % short in the base current; at RELTOL 1e-7 it
* agrees with the engine to 8 digits
.options reltol=1e-7 abstol=1e-15 vntol=1e-10
.lib pdk/ihp/ihp-sg13g2/libs.tech/ngspice/models/cornerHBT.lib hbt_typ
VC c 0 1.5
VB b 0 0.85
XQ1 c b 0 0 npn13G2 Nx=2
.dc VC 0 2 0.05 VB 0.85 0.95 0.05
.end
