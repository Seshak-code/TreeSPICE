* BSIM3v3.3 (LEVEL 49) PMOS common-source noise (NOIMOD 1: thermal from gm + gds + gmbs, flicker KF/AF)
VDD 1 0 DC 3
VIN 4 0 DC 2.1 AC 1
RS 4 2 1k
RD 3 0 5k
M1 3 2 1 1 PM W=20u L=0.6u
.model PM PMOS(LEVEL=49 VERSION=3.3 TNOM=27 TOX=7.5E-9 NCH=1.2E17 NSUB=5E16 VTH0=-0.5 K1=0.5 K2=0.01 K3=-3 NLX=2E-7 DVT0=1.2 DVT1=0.4 DVT2=-0.02 U0=130 UA=1.5E-9 UB=1.5E-18 UC=-4E-11 VSAT=7E4 A0=1.1 AGS=0.2 KETA=-0.02 RDSW=400 PRWG=0.1 PRWB=0.05 PCLM=1.2 PDIBLC1=0.25 PDIBLC2=0.004 DROUT=0.5 PSCBE1=4E8 PSCBE2=1E-5 DELTA=0.012 NFACTOR=1.3 CIT=1E-4 ETA0=0.07 ETAB=-0.04 VOFF=-0.12 XJ=1.5E-7 CGSO=2.5E-10 CGDO=2.5E-10 CJ=9E-4 CJSW=4E-10 MJ=0.45 PB=0.85 JS=1E-5 WINT=2E-8 LINT=3E-8 UTE=-1.3 KT1=-0.12 KT2=0.02 AT=2E4 PRT=40 AF=1.05 KF=1E-26)
.noise v(3) VIN dec 5 10 10g
.end
