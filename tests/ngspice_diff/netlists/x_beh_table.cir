TABLE for E and G, clamped at the ends (sampled away from corners: ngspice rounds them)
V1 a 0 DC -1
R0 a 0 1k
E1 o1 0 TABLE {V(a)} = (-0.5,0) (0,1) (0.5,3) (1,3.5)
R1 o1 0 1k
G1 0 o2 TABLE {V(a)*2} = (-1,-1m) (0,0) (1,2m)
R2 o2 0 1k
.dc V1 -0.88 0.87 0.25
.end
