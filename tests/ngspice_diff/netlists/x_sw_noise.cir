Noise with a switch in the circuit (small-signal ROFF, as .ac)
V1 1 0 DC 1 AC 1
R1 1 2 1k
S1 2 0 c 0 SM
Vc c 0 DC 1
R2 2 3 10k
R3 3 0 10k
.model SM SW(VT=0.5 VH=0.1 RON=50 ROFF=100k)
.noise v(3) V1 dec 3 100 100k
.end
