* XSPICE zener in AC: its incremental conductance at a reverse-biased operating point
VA a 0 DC -7 AC 1
R1 a z 100
a1 %gd(z 0) zm
.model zm zener(v_breakdown=5.6 i_breakdown=10m r_breakdown=5)
.ac dec 2 1k 1meg
.end
