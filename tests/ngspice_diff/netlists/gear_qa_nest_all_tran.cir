* QA: nested subckts holding D, Q (PNP+NPN with substrate), M; amplifier .dc (method=gear)
VCC 1 0 DC 5
VIN 2 0 DC 0.6  AC 1
X1 2 3 1 OUTER
RL 3 0 10k
.subckt INNER i o vcc
Q1 o i e 0 QN
RE e 0 100
D1 o vcc DM
Q2 vcc o p vcc QP
RP p 0 2k
MN1 vcc o m 0 NM W=20u L=1u AD=20p AS=20p PD=10u PS=10u
RM m 0 5k
.ends
.subckt OUTER i o vcc
X9 i n vcc INNER
R1 n o 1k
CN n 0 1p
.ends
.model QN NPN(IS=1e-15 BF=120 VAF=60 RB=50 CJE=1p CJC=1p TF=0.2n CJS=1p)
.model QP PNP(IS=1e-15 BF=60 VAF=40 CJE=1p CJC=1p TF=0.3n CJS=1p)
.model NM NMOS(VTO=0.7 KP=60u TOX=20n CGSO=3e-10 CGDO=3e-10 CJ=3e-4 CJSW=3e-10)
.model DM D(IS=1e-14 RS=2 CJO=1p TT=1n)
.options method=gear
.tran 0.2n 100n
.end
