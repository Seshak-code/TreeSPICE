* .sens: R/V/I sensitivities of a circuit with a diode, a BJT stage and a MOSFET stage (device parameters are listed unsupported)
VCC 1 0 DC 12
R1 1 2 47k
R2 2 0 10k
RC 1 3 4.7k
RE 4 0 1k
Q1 3 2 4 QN
RD 3 5 22k
D1 5 6 DM
R6 6 0 5.6k
I1 0 6 DC 20u
RG1 1 7 220k
RG2 7 0 100k
RM 1 8 10k
M1 8 7 0 0 NM W=20u L=2u
.model QN NPN (IS=1e-14 BF=150 VAF=100)
.model DM D (IS=1e-14 N=1.1)
.model NM NMOS (LEVEL=1 VTO=0.8 KP=60u LAMBDA=0.02)
.sens v(8)
.end
