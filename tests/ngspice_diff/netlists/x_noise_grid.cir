.noise dec over a non-integer number of decades: same grid as .ac
V1 1 0 DC 0 AC 1
R1 1 2 1k
R2 2 0 1k
C1 2 0 1n
.noise v(2) V1 dec 5 1k 3.3meg
.end
