POLY for F and H (current controlled)
V1 a 0 DC 0
V2 b 0 DC 0.3
R0 a 0 100
R00 b 0 100
F1 0 o1 POLY(1) V1 0 1 2
R1 o1 0 1k
F2 0 o2 POLY(2) V1 V2 0 1 2 3 4 5
R2 o2 0 1k
H1 o3 0 POLY(1) V1 0 1 2 3
R3 o3 0 1k
H2 o4 0 POLY(2) V1 V2 0 1 2 3 4 5
R4 o4 0 1k
.dc V1 -1 1 0.2
.end
