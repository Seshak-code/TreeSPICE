* BSIM3v3.3 (LEVEL 49) AC: common-source amplifier (capMod 3 intrinsic charges, overlap, junctions)
VDD 1 0 DC 3
VIN 4 0 DC 0 AC 1
C1 4 2 1u
VB 5 0 DC 0.9
RB 5 2 1meg
RD 1 3 5k
M1 3 2 0 0 NM W=10u L=0.5u AD=10p AS=10p PD=12u PS=12u
.model NM NMOS(LEVEL=49 VERSION=3.3 TNOM=27 TOX=7.5E-9 NCH=1.7E17 NSUB=5E16 VTH0=0.45 K1=0.55 K2=0.02 K3=-5 NLX=2E-7 DVT0=1.5 DVT1=0.4 DVT2=-0.02 U0=420 UA=1E-9 UB=1.2E-18 UC=-5E-11 VSAT=9E4 A0=1.2 AGS=0.3 KETA=-0.03 RDSW=300 PRWG=0.1 PRWB=0.05 WR=1 PCLM=1.0 PDIBLC1=0.2 PDIBLC2=0.005 DROUT=0.5 PSCBE1=5E8 PSCBE2=1E-5 DELTA=0.012 NFACTOR=1.2 CIT=1E-4 CDSC=1E-4 ETA0=0.06 ETAB=-0.05 VOFF=-0.1 XJ=1.5E-7 CGSO=2E-10 CGDO=2E-10 CGBO=1E-10 CJ=8E-4 CJSW=4E-10 MJ=0.4 PB=0.9 JS=1E-5 WINT=2E-8 LINT=3E-8 VBM=-2 UTE=-1.4 KT1=-0.1 KT2=0.02 UA1=3E-9 AT=2E4 PRT=50 XTI=3 PBSW=0.9 MJSW=0.35 RSH=15)
.ac dec 10 1k 100g
.end
