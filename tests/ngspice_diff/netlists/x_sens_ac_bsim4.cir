* .sens ac: BSIM4 (OSDI bsim4va in the engine) common-source stage
.model nb nmos (level=54 version=4.8 vth0=0.45 toxe=4n u0=0.04 vsat=1e5 k1=0.5 rdsw=150 pclm=1.3 cgso=2e-10 cgdo=2e-10)
VDD 1 0 DC 1.8
VG 2 0 DC 0.8 AC 1
M1 3 2 0 0 nb W=2u L=0.5u
R1 1 3 5k
C1 3 0 20f
.sens v(3) ac dec 2 1meg 10g
.end
