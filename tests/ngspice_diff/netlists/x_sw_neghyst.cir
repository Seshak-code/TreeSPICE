* Voltage and current switches with negative hysteresis (VH, IH < 0): the band between VT + VH and VT - VH is
* inverted (entering it from on turns the switch off, from off turns it on), against positive and zero hysteresis
vc c 0 sin(0 2 1meg)
vs s 0 DC 1
r1 s o1 1k
s1 o1 0 c 0 sneg
.model sneg sw(vt=0.5 vh=-0.3 ron=10 roff=1meg)
r2 s o2 1k
s2 o2 0 c 0 spos
.model spos sw(vt=0.5 vh=0.3 ron=10 roff=1meg)
r3 s o3 1k
s3 o3 0 c 0 szero
.model szero sw(vt=-0.2 ron=10 roff=1meg)
vi i 0 sin(0 2 700k)
ri i 0 1k
r4 s o4 1k
w1 o4 0 vi wneg
.model wneg csw(it=0.5m ih=-0.4m ron=10 roff=1meg)
.tran 5n 3u
.end
