* IHP SG13G2 antenna diodes (dantenna, dpantenna): ISR recombination, NBV breakdown, AREA from the cell's DEV_A / DEV_P / DEV_C
.lib pdk/ihp/ihp-sg13g2/libs.tech/ngspice/models/cornerDIO.lib dio_tt
V1 1 0 DC 0
R1 1 2 1k
XD1 0 2 dantenna l=10e-6 w=10e-6
R2 1 3 1k
XD2 3 0 dpantenna l=10e-6 w=10e-6
.dc V1 -1 14 0.1
.end
