* MOS level 9 (ngspice's mos9: level 3 with its 1 um effective-size floor): output curves, NMOS and PMOS
VD d 0 DC 3
VG g 0 DC 1.5
M1 d g 0 0 n9 W=20u L=2u
VDP dp 0 DC -3
M2 dp gp 0 0 p9 W=40u L=3u
VGP gp 0 DC -1.5
.model n9 nmos level=9 vto=0.7 kp=60u gamma=0.5 phi=0.7 tox=20n uo=500 nsub=1e16 vmax=1e5 eta=0.1 theta=0.05 kappa=0.3 xj=0.3u ld=0.1u cgso=2e-10 cgdo=2e-10 cj=2e-4 cjsw=1e-9
.model p9 pmos level=9 vto=-0.8 kp=25u gamma=0.6 phi=0.7 tox=20n uo=200 nsub=2e16 vmax=8e4 eta=0.08 theta=0.06 kappa=0.25 xj=0.3u ld=0.1u
.dc VD 0 3 0.05 VG 0.5 2.5 0.5
.end
