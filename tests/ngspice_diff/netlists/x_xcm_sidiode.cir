* XSPICE sidiode: plain on / off / reverse conductances, then quadratic overlaps (epsilon, revepsilon) with tanh
* current limits, swept through every region
v1 a 0 DC 0
a1 a 0 d1
.model d1 sidiode(ron=10 roff=100k vfwd=0.6 vrev=5 rrev=50)
r1 a b 100
a2 b 0 d2
.model d2 sidiode(ron=2 roff=1meg rrev=20 vfwd=0.7 vrev=3 ilimit=20m revilimit=30m epsilon=0.2 revepsilon=0.3)
* ngspice's partial in the tanh limits is g (1 - tanh^2), not exact: its sweep stops at RELTOL there; tight options
.options reltol=1e-7 abstol=1e-15 vntol=1e-12
.dc v1 -8 4 0.02
.print dc i(v1) v(b)
.end
