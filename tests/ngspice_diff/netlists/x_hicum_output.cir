* HICUM/L2: output characteristics at three base voltages (internal thermal node: 4 terminals)
VC c 0 2
VB b 0 0.8
Q1 c b 0 0 qh
.model qh npn level=8 c10=2e-30 qp0=2e-14 ich=1e-2 hfe=100 hfc=10 cjei0=1e-14 vdei=0.9 zei=0.5 rbi0=10 rbx=5 rcx=5 re=2 t0=1e-12 cjci0=5e-15 vdci=0.7 zci=0.4 ibeis=1e-18 mbei=1 ireis=1e-16 mrei=2 rth=200 cth=1e-12 favl=1 qavl=5e-14 cjs0=3e-15 itss=1e-20 rsu=100 csu=1e-15 flsh=1
.dc VC 0 3 0.05 VB 0.75 0.85 0.05
.end
