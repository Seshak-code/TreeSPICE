* MOS level 1 transfer curve at -40, 27 and 125 C: KP/T^1.5, PHI, VTO with GAMMA, the bulk junction IS
V1 dd 0 DC 3
RD dd d 2k
VG g 0 DC 0
VB b 0 DC -0.5
M1 d g 0 b NM W=20u L=2u
.model NM NMOS(VTO=0.8 KP=60u GAMMA=0.45 PHI=0.65 LAMBDA=0.02 IS=1e-14 PB=0.75)
.temp -40 27 125
.dc VG 0 3 0.25
.end
