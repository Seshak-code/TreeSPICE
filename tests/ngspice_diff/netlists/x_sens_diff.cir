* .sens: differential output v(2,3) of a bridge
V1 1 0 DC 10
R1 1 2 1k
R2 2 0 2k
R3 1 3 1.5k
R4 3 0 1k
RL 2 3 10k
.sens v(2,3)
.end
