* Flicker noise of M parallel diodes and BJTs with AF != 1: M KF (I/M)^AF / f (ngspice dionoise, bjtnoise)
VCC vcc 0 DC 5
VIN in 0 DC 0.65 AC 1
RB in b 1k
Q1 c b 0 qn M=4
RC vcc c 1k
D1 c x dn M=3
RX x 0 5k
.model qn NPN(IS=1e-15 BF=120 VAF=60 KF=1e-12 AF=1.6)
.model dn D(IS=1e-14 N=1.1 KF=1e-11 AF=1.4)
.noise v(c) VIN dec 5 1 100k
.end
