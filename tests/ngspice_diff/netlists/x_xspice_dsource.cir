* XSPICE d_source: a vector file (comments, a blank line, comma and = separators, every strength) drives a NAND
* and a tristate bus with a pullup; a second source whose file has no t = 0 row starts at U
a_src [a b c] src
.model src d_source(input_file="lib/x_dsource.txt")
a_late [d] late
.model late d_source(input_file="lib/x_dsource_late.txt")
a_n [a b] y nand
.model nand d_nand(rise_delay=0.2n fall_delay=0.3n)
a_pu c pu
.model pu d_pullup
a_x [d a] z xor
.model xor d_xor
a_dac [y c z] [v1 v2 v3] dac_mod
.model dac_mod dac_bridge(out_low=0 out_high=3.3 t_rise=0.1n t_fall=0.1n)
r1 v1 0 1k
r2 v2 0 1k
r3 v3 0 1k
.tran 0.1n 14n
.control
run
print v(v1) v(v2) v(v3)
eprint a b c d y z
.endc
.end
