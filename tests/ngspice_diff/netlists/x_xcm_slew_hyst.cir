* XSPICE slew (the output chases the input at its rise / fall rates) and hyst (a Schmitt characteristic with
* smoothed corners) on a triangle and a sine
VT t 0 PWL(0 0 2u 2 2.5u 2 2.6u 0 4u 1 5u 1)
a1 t o1 sl
.model sl slew(rise_slope=0.5meg fall_slope=2meg)
VS s 0 SIN(0.5 0.9 300k)
a2 s o2 hy
.model hy hyst(in_low=0.2 in_high=0.8 hyst=0.15 out_lower_limit=-1 out_upper_limit=2 input_domain=0.02)
R1 o1 0 1k
R2 o2 0 1k
.tran 5n 6u
.end
