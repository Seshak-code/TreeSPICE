* Diode forward sweep at -40, 27 and 125 C: IS with EG/XTI, N, RS with TRS1
V1 1 0 0
R1 1 2 100
D1 2 3 DM
D2 3 0 DM2 area=2
.model DM D(IS=2e-14 N=1.05 RS=2 TRS1=0.002 EG=1.12 XTI=3.2)
.model DM2 D(IS=1e-15 EG=0.7 XTI=2 TNOM=35)
.options reltol=1e-6
.temp -40 27 125
.dc V1 0 2 0.1
.end
