* MOS level 6 (ngspice mos6, Sakurai-Newton n-th power law): output curves with GAMMA1, SIGMA, LAMBDA0/LAMBDA1, reverse mode
VD d 0 DC 3
VG g 0 DC 1.5
VB b 0 DC -0.5
M1 d g 0 b n6 W=20u L=2u
.model n6 nmos level=6 vto=0.7 kv=1.8 nv=0.8 kc=4e-5 nc=1.3 gamma=0.4 gamma1=0.05 sigma=0.02 phi=0.7 lambda0=0.03 lambda1=0.01 ld=0.1u
.dc VD -1 3 0.05 VG 0.5 2.5 0.5
.end
