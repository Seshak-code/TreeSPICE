* OFF on a diode and a JFET whose operating point is unique: released from 0 V, they end where they would anyway
VCC 1 0 5
R3 1 3 2k
D1 3 0 dm OFF
.model dm d is=1e-14
VG 4 0 DC -0.5
R4 1 5 1k
J1 5 4 0 jn OFF
.model jn njf vto=-2 beta=1m
.op
.end
