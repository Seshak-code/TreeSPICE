* MOS level 6: PHI, GAMMA and VTO from NSUB / NSS / TPG, transfer curve with junction saturation current density
VD d 0 DC 2
VG g 0 DC 0
VB b 0 DC 0
M1 d g 0 b n6 W=10u L=1u AD=20p AS=20p
.model n6 nmos level=6 kv=1.5 nv=0.7 nc=1.4 tox=25n u0=450 nsub=3e16 nss=1e10 tpg=1 js=1e-4 lambda=0.02
.dc VG 0 3 0.05 VB 0 -1 -0.5
.end
