* Diode reverse breakdown with TCV, hot and cold; instance TEMP and DTEMP
V1 1 0 DC 0
R1 1 2 1k
D1 0 2 DZ
R2 1 3 1k
D2 0 3 DZ dtemp=40
R3 1 4 1k
D3 0 4 DZ temp=-20
.model DZ D(IS=1e-14 BV=5.1 IBV=5m TCV=0.002)
.temp 85
.dc V1 0 8 0.25
.end
