* URC with N given and a diode-backed line (ISPERL, RSPERL): a pulse through it
VIN in 0 PULSE(0 1 1n 0.1n 0.1n 20n 50n)
RS in a 50
U1 a b 0 um L=100u N=6
U2 a c 0 ud L=50u
RL b 0 10k
RL2 c 0 10k
.model um URC(RPERL=20k CPERL=2e-9)
.model ud URC(RPERL=5k CPERL=1e-9 ISPERL=1e-12 RSPERL=10)
.tran 0.1n 60n
.end
