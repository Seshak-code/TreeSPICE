* JFET M=3: every term scales (ngspice jfetload: m on every stamp), forward gate current, RD/RS
VD d 0 DC 5
VG g 0 DC 0.5
J1 d g 0 jn M=3
.model jn NJF(VTO=-2 BETA=1e-3 LAMBDA=0.02 IS=1e-12 RD=50 RS=20 CGS=2p CGD=1p)
.dc VG -2 0.8 0.05 VD 1 5 2
.end
