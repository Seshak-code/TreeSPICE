* MOS level 3: Id-Vgs with subthreshold NFS, THETA, ETA static feedback, KAPPA length modulation, XJ short channel, body effect
VDD d 0 DC 3
VG g 0 DC 0
VB b 0 DC 0
M1 d g 0 b NM W=20u L=2u M=2
.model NM NMOS(LEVEL=3 VTO=0.8 KP=40u GAMMA=0.5 PHI=0.65 TOX=50n NFS=1e11 THETA=0.1 ETA=0.5 KAPPA=0.3 XJ=0.2u NSUB=1e16 DELTA=0.5)
.dc VG 0 3 0.25 VB 0 -2 -1
.end
