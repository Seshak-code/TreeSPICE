C model cards with instance TC1/TC2 overriding the model's (TNOM shifts the 27 C value), L/W geometry, M
V1 1 0 DC 0 AC 1
R1 1 2 1k
C1 2 0 CM1 L=20u W=5u
R2 1 3 1k
C2 3 0 1n CM2 TC1=2e-3 TC2=0
R3 1 4 1k
C3 4 0 CM2 L=10u W=10u M=2 TC2=1e-5
.model CM1 C(CJ=1e-3 CJSW=1e-10 TNOM=0 TC1=1e-3 TC2=1e-5 NARROW=0.1u SHORT=0.2u)
.model CM2 C(CJ=2e-4 DEFW=3u TNOM=10 TC1=5e-3 TC2=2e-5)
.ac dec 3 1k 1g
.end
