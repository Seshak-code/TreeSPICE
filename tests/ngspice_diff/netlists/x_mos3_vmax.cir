* MOS level 3 with velocity saturation VMAX (the emax length modulation) and no NSUB
VD d 0 DC 0
VG g 0 DC 0
M1 d g 0 0 NM W=10u L=1.5u
.model NM NMOS(LEVEL=3 VTO=0.7 KP=30u GAMMA=0.4 PHI=0.7 TOX=40n THETA=0.1 VMAX=1.5e5 KAPPA=0.3 NFS=5e10)
M2 d g 0 0 NN W=10u L=1.5u
.model NN NMOS(LEVEL=3 VTO=0.7 KP=30u GAMMA=0.4 PHI=0.7 TOX=40n THETA=0.1 VMAX=1.5e5 KAPPA=0.3 NSUB=3e16 XJ=0.1u)
.dc VD 0 5 0.25 VG 1 3 1
.end
