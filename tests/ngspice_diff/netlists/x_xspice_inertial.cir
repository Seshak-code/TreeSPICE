* XSPICE inertial delay: glitches shorter than a gate's delay vanish (a buffer, an AND, an inverter); a transport
* buffer next to them passes them; a third value (U from the adc's band) while a change is pending
vin in_a 0 pwl(0 0 2n 0 2.05n 3 2.25n 3 2.3n 0 5n 0 5.05n 3 8n 3 8.05n 0 11n 0 11.05n 1.5 11.3n 1.5 11.35n 3 14n 3)
a_adc [in_a] [d_in] adc_mod
.model adc_mod adc_bridge(in_low=1.0 in_high=2.0 rise_delay=0.05n fall_delay=0.05n)
a_buf d_in d_buf ibuf
.model ibuf d_buffer(rise_delay=0.5n fall_delay=0.4n inertial_delay=true)
a_tb d_in d_tbuf tbuf
.model tbuf d_buffer(rise_delay=0.5n fall_delay=0.4n)
a_pu d_hi pu
.model pu d_pullup
a_and [d_in d_hi] d_and iand
.model iand d_and(rise_delay=0.6n fall_delay=0.6n inertial_delay=true)
a_inv d_in d_inv iinv
.model iinv d_inverter(rise_delay=0.3n fall_delay=0.3n inertial_delay=true)
a_dac [d_buf d_tbuf d_and d_inv] [o1 o2 o3 o4] dac_mod
.model dac_mod dac_bridge(out_low=0 out_high=3.3 t_rise=0.1n t_fall=0.1n)
.tran 0.05n 15n
.control
run
print v(o1) v(o2) v(o3) v(o4)
eprint d_buf d_tbuf d_and d_inv
.endc
.end
