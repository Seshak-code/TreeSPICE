x_step_op: nested .step: a source, then a resistor (the first card is the outermost loop)
V1 in 0 DC 1
R1 in out 1k
R2 out 0 1k
.step V1 1 3 1
.step R2 list 1k 3k
.op
.print op v(out)
.end
