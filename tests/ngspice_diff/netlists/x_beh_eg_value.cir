E and G with VALUE=, vol=, cur=: DC sweep
V1 a 0 DC 0
V2 b 0 DC 0.3
R0 a 0 1k
R00 b 0 1k
E1 o1 0 VALUE={V(a)*V(b)+2*V(a)}
R1 o1 0 1k
E2 o2 0 vol='sin(V(a))+V(a,b)'
R2 o2 0 1k
G1 0 o3 VALUE={V(a)^2*1m}
R3 o3 0 1k
G2 0 o4 cur='tanh(V(a)-V(b))*1m'
R4 o4 0 1k
.dc V1 0 1 0.1
.end
