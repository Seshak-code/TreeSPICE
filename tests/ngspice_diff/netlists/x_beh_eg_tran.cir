E VALUE with time
V1 a 0 SIN(0 1 1k)
R0 a 0 1k
E1 o1 0 VALUE={V(a)*0.5+0.1*time*1k}
R1 o1 x 1k
C1 x 0 100n
G1 0 o2 VALUE={V(a)*V(a)*1m}
R2 o2 0 1k
.tran 10u 2m
.end
