* XSPICE int and d_dt in AC: gain/jw and gain jw from their operating points
VA a 0 DC 0.1 AC 1
a1 a o1 i1
.model i1 int(gain=1e3 out_lower_limit=-10 out_upper_limit=10)
a2 a o2 d1
.model d1 d_dt(gain=1e-3 out_lower_limit=-10 out_upper_limit=10)
R1 o1 0 1k
R2 o2 0 1k
.ac dec 5 10 100k
.end
