* XSPICE d_osc: a control stepping through its table (and past its end, the last segment extended), duty cycles,
* init_phase 90 / -90, and 170 (the first edge within a quarter half period of t = 0: the t = 0 call already posts it).
* Each control step comes 0.1 ns after an edge, so the next 3/4-half-period decision falls after it: a step inside
* that window is a missed edge, which ngspice settles by rejecting the step (where its steps fall decides the edge)
vc c 0 pwl(0 0.5 32.1n 0.5 32.2n 2 70.43n 2 70.53n -0.5 117.1n -0.5 117.2n 1)
vk k 0 DC 0.25
a_o1 c o1 osc1
.model osc1 d_osc(cntl_array=[0 1 2] freq_array=[100meg 150meg 300meg])
a_o2 k o2 osc2
.model osc2 d_osc(cntl_array=[-1 1] freq_array=[50meg 150meg] duty_cycle=0.3 init_phase=90)
a_o3 k o3 osc3
.model osc3 d_osc(cntl_array=[-1 1] freq_array=[50meg 150meg] duty_cycle=0.3 init_phase=-90)
a_o4 k o4 osc4
.model osc4 d_osc(cntl_array=[-1 1] freq_array=[50meg 150meg] init_phase=170)
a_dac [o1 o2] [v1 v2] dac_mod
.model dac_mod dac_bridge(out_low=0 out_high=3.3 t_rise=0.1n t_fall=0.1n)
r1 v1 0 1k
r2 v2 0 1k
.tran 0.1n 160n
.control
run
print v(v1) v(v2)
eprint o1 o2 o3 o4
.endc
.end
