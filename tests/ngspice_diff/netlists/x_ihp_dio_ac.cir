* IHP SG13G2 antenna diodes reverse biased: AC (junction and transit charges)
.lib pdk/ihp/ihp-sg13g2/libs.tech/ngspice/models/cornerDIO.lib dio_tt
V1 1 0 DC 3 AC 1
R1 1 2 10k
XD1 0 2 dantenna l=10e-6 w=10e-6
R2 1 3 10k
XD2 3 0 dpantenna l=10e-6 w=10e-6
.ac dec 10 1k 10g
.end
