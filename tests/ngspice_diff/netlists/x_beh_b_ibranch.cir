B sources reading branch currents I(Vsrc) and I(L)
V1 a 0 DC 1
R0 a b 100
Vs b 0 DC 0
L1 a c 1m
R1 c 0 50
B1 o1 0 V=I(Vs)*-100
R2 o2 0 1k
B2 o2 0 I=-I(L1)*2
R3 o1 0 1k
B3 o3 0 V=I(B1)*1e3
R4 o3 0 1k
.op
.end
