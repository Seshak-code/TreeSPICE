* XSPICE d_state: a state table with continuation rows and an x input, a reset pulse, an input at U, and a second
* machine whose clock is 1 from t = 0: XSPICE's previous clock starts at 0, so its first input change clocks it
a_stim [clk en rst clk2 en2] stim
.model stim d_source(input_file="lib/x_dstate_stim.txt")
a_s1 [en] clk rst [q0 q1] sm1
.model sm1 d_state(state_file="lib/x_dstate.txt" clk_delay=0.3n reset_delay=0.6n)
a_s2 [en2] clk2 NULL [r0 r1] sm2
.model sm2 d_state(state_file="lib/x_dstate.txt" reset_state=2)
a_pu q0 pu
.model pu d_pullup
a_dac [q0 q1 r0 r1] [v1 v2 v3 v4] dac_mod
.model dac_mod dac_bridge(out_low=0 out_high=3.3 t_rise=0.1n t_fall=0.1n)
r1 v1 0 1k
r2 v2 0 1k
r3 v3 0 1k
r4 v4 0 1k
.tran 0.1n 42n
.control
run
print v(v1) v(v2) v(v3) v(v4)
eprint clk en rst q0 q1 r0 r1
.endc
.end
