* Diode RSW small-signal: the sidewall's depletion capacitance at A_sw behind RSW, forward and reverse bias (the bottom's characteristic is
* checked in test_engine_fixes)
VB 1 0 DC 0.68 AC 1
R1 1 2 100
D1 2 0 DS PJ=50u
VR 3 0 DC -3 AC 1
R2 3 4 10k
D2 4 0 DS PJ=50u
.model DS D(IS=1e-14 TT=2n CJO=2p RS=4 JSW=1e-9 NS=1.1 CJSW=2e-7 MJSW=0.4 PHP=0.8 RSW=200)
.ac dec 10 1k 10G
.end
