* BSIM3v3.3 (LEVEL 49) on OSDI bsim3_va: NMOS Id-Vgs with body bias and Id-Vds family (incl. reversed drain), RSH series resistance, short and long device
VD d 0 DC 0
VG g 0 DC 0
VB b 0 DC 0
M1 d g 0 b NM W=10u L=1u
M2 d g 0 b NM W=0.5u L=0.18u AD=0.2p AS=0.2p PD=1.8u PS=1.8u NRD=2 NRS=2
.model NM NMOS(LEVEL=49 VERSION=3.3 TNOM=27 TOX=7.5E-9 NCH=1.7E17 NSUB=5E16 VTH0=0.45 K1=0.55 K2=0.02 K3=-5 NLX=2E-7 DVT0=1.5 DVT1=0.4 DVT2=-0.02 U0=420 UA=1E-9 UB=1.2E-18 UC=-5E-11 VSAT=9E4 A0=1.2 AGS=0.3 KETA=-0.03 RDSW=300 PRWG=0.1 PRWB=0.05 WR=1 PCLM=1.0 PDIBLC1=0.2 PDIBLC2=0.005 DROUT=0.5 PSCBE1=5E8 PSCBE2=1E-5 DELTA=0.012 NFACTOR=1.2 CIT=1E-4 CDSC=1E-4 ETA0=0.06 ETAB=-0.05 VOFF=-0.1 XJ=1.5E-7 CGSO=2E-10 CGDO=2E-10 CGBO=1E-10 CJ=8E-4 CJSW=4E-10 MJ=0.4 PB=0.9 JS=1E-5 WINT=2E-8 LINT=3E-8 VBM=-2 UTE=-1.4 KT1=-0.1 KT2=0.02 UA1=3E-9 AT=2E4 PRT=50 XTI=3 PBSW=0.9 MJSW=0.35 RSH=15)
.dc VD -1 3 0.25 VG 0.5 2.5 1
.end
