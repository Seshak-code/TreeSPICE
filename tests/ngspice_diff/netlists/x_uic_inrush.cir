* UIC start: supply current must not ring (diode/BJT junction charges, MOS1 Meyer charges, IC= caps)
VDD 1 0 DC 3
VIN 2 0 DC 0
R1 1 5 1k
D1 5 6 dm
C1 6 0 1n IC=0.5
RB 1 7 10k
Q1 8 7 0 qm
RC 1 8 2k
CL 8 0 100p
M1 9 2 1 1 pm w=20u l=1u
M2 9 2 0 0 nm w=10u l=1u
C3 9 0 1p
.ic v(5)=0.2 v(8)=1 v(9)=0.4
.model dm D (is=1e-14 cjo=2p tt=1n m=0.5 vj=0.7)
.model qm npn (is=1e-15 bf=100 cje=2p cjc=1p tf=0.2n)
.model nm nmos (level=1 vto=0.7 kp=50u cgso=1n cgdo=1n cgbo=1n)
.model pm pmos (level=1 vto=-0.7 kp=25u cgso=1n cgdo=1n cgbo=1n)
.tran 20p 20n uic
.end
