* XSPICE pwlts: a piecewise-linear source in time, smoothed at its corners (fraction, then an absolute domain) with
* breakpoints there, extended past its ends (limit holds the second)
a1 o1 p1
.model p1 pwlts(x_array=[1n 5n 6n 12n] y_array=[0 2 -1 0.5] input_domain=0.2)
a2 o2 p2
.model p2 pwlts(x_array=[2n 4n 9n] y_array=[1 3 0] input_domain=0.3n fraction=false limit=true)
r1 o1 0 1k
r2 o2 0 1k
.tran 0.1n 15n
.end
