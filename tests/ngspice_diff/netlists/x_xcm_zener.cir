* XSPICE zener: forward, linear and breakdown regions (a 3-segment one, and a 2-segment one at low breakdown)
VA a 0 DC 0
R1 a z1 100
a1 %gd(z1 0) zm
.model zm zener(v_breakdown=5.6 i_breakdown=10m r_breakdown=5 i_rev=1u i_sat=1e-12 n_forward=1.1)
R2 a z2 100
a2 %gd(z2 0) zl
.model zl zener(v_breakdown=0.3 i_breakdown=1m r_breakdown=50 i_rev=1e-9 i_sat=1e-14)
.options reltol=1e-7 abstol=1e-15 vntol=1e-12
.dc VA -8 2 0.01
.end
