B sources: AC is the small-signal linearisation at the operating point
V1 a 0 DC 0.2 AC 1
R0 a 0 1k
B1 o1 0 V=3*V(a)
R1 o1 x 1k
C1 x 0 1u
B2 o2 0 V=tanh(2*V(a))
R2 o2 y 1k
C2 y 0 1u
B3 o3 0 I=V(a)*V(a)*1m
R3 o3 0 1k
C3 o3 0 1u
.ac dec 5 10 100k
.end
