.ac dec within one decade: standard steps, the last point stays below fstop
V1 in 0 DC 0 AC 1
R1 in out 1k
C1 out 0 100n
.ac dec 10 10 70
.end
