* Diode RSW: the separate sidewall node (ngspice dioload), its own characteristic (NS) with IKP and breakdown
* (none on the sidewall)
VD a 0 DC 0
R1 a k1 50
D1 k1 0 DA PJ=40u
.model DA D(IS=1e-14 N=1.05 RS=3 JSW=2e-9 NS=1.3 IKP=1e-6 RSW=2e3 BV=6 IBV=1e-5)
.temp 80
.dc VD -8 1.5 0.02
.end
