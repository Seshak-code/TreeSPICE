* MOS level 2: Baum velocity saturation (VMAX, NEFF) with the length-modulation law from NSUB
VD d 0 DC 0
VG g 0 DC 0
M1 d g 0 0 NM W=10u L=1.5u
.model NM NMOS(LEVEL=2 VTO=0.7 KP=30u GAMMA=0.4 PHI=0.7 TOX=40n UCRIT=1e4 UEXP=0.2 VMAX=5e4 NEFF=2 NSUB=2e16)
.dc VD 0 5 0.25 VG 1 3 1
.print dc i(VD)
.end
