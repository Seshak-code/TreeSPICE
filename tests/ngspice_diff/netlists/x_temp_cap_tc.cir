* Capacitor TC1/TC2 (instance and model TNOM) in an RC low pass at 85 C
V1 in 0 DC 0 AC 1
R1 in out 1k tc1=0.002
C1 out 0 1n tc1=0.01 tc2=1e-5
C2 out 0 cm tc1=0.005
.model cm C(cap=1n tnom=20 tc1=0.003 tc2=2e-6)
.options temp=85
.ac dec 5 10k 10meg
.end
