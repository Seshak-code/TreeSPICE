* MOS level 2: Id-Vds family through the linear/saturation boundary and into reverse (swapped drain/source)
VD d 0 DC 0
VG g 0 DC 0
M1 d g 0 0 NM W=10u L=3u
.model NM NMOS(LEVEL=2 VTO=0.7 KP=30u GAMMA=0.4 PHI=0.7 LAMBDA=0.05 TOX=40n UCRIT=1e4 UEXP=0.2 XJ=0.1u NSUB=2e16)
.dc VD -3 5 0.25 VG 1 3 1
.print dc i(VD)
.end
