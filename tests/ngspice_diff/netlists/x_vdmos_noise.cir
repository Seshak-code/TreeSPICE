* VDMOS noise: RD, RS thermal, channel 2/3 gm thermal, flicker KF |Id|^AF / (f Cox^2), M=2
VDD vdd 0 DC 15
VG g0 0 DC 3.8 AC 1
RG g0 g 100
RL vdd d 20
M1 d g 0 nz M=2
.model nz VDMOS(Vto=3 Kp=4 lambda=0.01 Rd=0.2 Rs=0.1 kf=1e-27 af=1.3)
.noise v(d) VG dec 10 10 100meg
.end
