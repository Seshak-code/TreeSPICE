* OFF: a BJT latch whose OFF transistor starts held off (ngspice INITFIX); it ends off
VCC 1 0 5
RC1 1 c1 1k
RC2 1 c2 1.2k
RB1 c2 b1 10k
RB2 c1 b2 10k
Q1 c1 b1 0 qn OFF
Q2 c2 b2 0 qn
.model qn npn bf=100
.op
.end
