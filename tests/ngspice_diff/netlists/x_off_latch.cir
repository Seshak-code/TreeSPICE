* OFF (D, Q, J): a BJT latch whose OFF transistor starts held off; a diode and a JFET marked OFF where the operating point is unique
VCC 1 0 5
RC1 1 c1 1k
RC2 1 c2 1.2k
RB1 c2 b1 10k
RB2 c1 b2 10k
Q1 c1 b1 0 qn OFF
Q2 c2 b2 0 qn
.model qn npn bf=100
R3 1 3 2k
D1 3 0 dm OFF
.model dm d is=1e-14
VG 4 0 DC -0.5
R4 1 5 1k
J1 5 4 0 jn OFF
.model jn njf vto=-2 beta=1m
.op
.end
