* QA: Meyer regions in one transient — gate ramped cutoff -> depletion -> weak -> strong inversion, (method=gear)
* drain pulled through vdsat (VDS high -> low as the channel turns on)
VDD 1 0 DC 5
VIN 2 0 PULSE(-2 5 1u 20u 20u 1u 50u)
RD 1 3 10k
M1 3 2 0 0 NM W=20u L=1u
.model NM NMOS(KP=100u VTO=0.7 LAMBDA=0.02 TOX=40n CGSO=2n CGDO=2n CGBO=1n CBD=20f CBS=20f)
.options method=gear
.tran 0.5u 60u
.end
