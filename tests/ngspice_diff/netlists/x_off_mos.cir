* MOSFET OFF: a cross-coupled NMOS latch with resistor loads whose OFF transistor starts held off (ngspice INITFIX);
* level 2 and level 6 devices marked OFF where the operating point is unique
VDD 1 0 5
RL1 1 a 10k
RL2 1 b 12k
M1 a b 0 0 nm OFF
M2 b a 0 0 nm
.model nm nmos level=1 vto=1 kp=50u
R3 1 c 5k
M3 c c 0 0 n2 L=2u W=10u OFF
.model n2 nmos level=2 vto=0.8 kp=40u tox=50n
R4 1 d 5k
M4 d 1 0 0 n6 OFF
.model n6 nmos level=6 vto=0.7 kc=4e-5 nc=1.3
.op
.end
