B source as a diode: converges only with an exact Jacobian
V1 in 0 DC 0
R1 in a 1k
B1 a 0 I=1e-14*(exp(V(a)/0.025)-1)
.dc V1 0 5 0.25
.end
