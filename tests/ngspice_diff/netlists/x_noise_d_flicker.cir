Diode flicker noise KF, AF
V1 1 0 DC 3 AC 1
R1 1 2 10k
D1 2 0 DX
.model DX D(IS=1e-14 KF=1e-12 AF=1.2)
.noise v(2) V1 dec 4 1 100meg
.end
